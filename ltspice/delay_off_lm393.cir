* Pi power HAT: delay-off timer, LM2903B redesign (docs/SPEC.md sections 2-4; the old TLC555 design is
* delay_off_timer.cir, kept unchanged).
* U1 = LM2903B dual comparator on BATT (always powered). No LTspice model: behavioural open-collector stand-in with
* the SLCS005AH 5.6 limits (offset, input bias out of the pins, VOL, minimum supply).
*   U1A: IN- = C5_T (timing capacitor), IN+ = REF; output DRV pulls the Q1 gate network (R15 to Q1_G, R14 to BATT).
*   U1B: IN- = ACC_S, IN+ = REF; output STAT_O -> R21 -> J5 (Pi GPIO, its pull-up): low = ACC on.
*   REF = BATT divider R4/R5 with hysteresis R23 to DRV (lower trip while Q1 is on).
* ACC_S = J1 ACC through D5, or BATT through SW1 and D4; R8 pull-down. ACC_S -> R24 -> D6 -> C5_T; R9 discharges C5.
* Q1 P-FET (SQD50P04-13L stand-in, no slew capacitor), constant-power load on VOUT, harness R + L to the battery.
* Run: LTspice.exe -b delay_off_lm393.cir  (results: delay_off_lm393.log, .meas lines)
*
* One run: battery hot-plug at T_PLUG (all capacitors empty), key on, key off; key on, off, on again mid-delay, off;
* a short ACC blip. Steps: battery voltage, component corner, load.
*   CORNER 1 = short delay: C5 low (tolerance x temperature), R9 low, REF high (resistor tolerance, VOL at its limit,
*              IN+ bias at its limit, offset), diodes at their maximum drop, D6 leakage and C5 insulation at their
*              bounds, Q1 threshold at its cold maximum (weakest gate drive)
*   CORNER 2 = nominal
*   CORNER 3 = long delay: C5 high, R9 high, REF low, IN- bias at its limit (into C5), diodes at a low drop,
*              Q1 threshold at its hot minimum (hot-plug and off-state margin)
*   LOAD 1 = Pi 5 + buck at full load, the Pi shuts down T_PISD after key-off (USB keeps charging):
*            BATT rises at the board during the delay
*   LOAD 2 = full load through the whole delay (largest turn-off stress, chatter check at full IR drop)

.param VB=12
.step param VB list 9 12 14.4
.step param CORNER list 1 2 3
.step param LOAD list 1 2

* ---- timing parts
.param R9NOM=4.7e6
.param RTOL=0.01
* C5NOM = C5 + C27 + C28 in parallel (3 x 10 uF, SPEC 3)
.param C5NOM=30u
* DC bias: C(V) = C5NOM x (1 - DCB x V), assumption (SPEC 3); charge form below
.param DCB=0.04
* CF_SHORT = (1 - tolerance) x (1 - temperature limit) x (1 - aging), SPEC 3
.param CF_SHORT=0.6885
.param CF_LONG=1.265
.param CF=if(CORNER==1, CF_SHORT, if(CORNER==3, CF_LONG, 1))
.param RF=if(CORNER==1, 1-RTOL, if(CORNER==3, 1+RTOL, 1))
* C5 network insulation from the chosen part's ohm x farad figure (Cal-Chip GMC X7R) and D6 reverse leakage bound
* (BAS116LT1G, 150 C)
.param C5_OHM_F=1000
.param RIR=if(CORNER==1, C5_OHM_F/C5NOM, 1e15)
.param ILEAK=if(CORNER==1, 80n, 0)

* ---- LM2903B limits (SLCS005AH 5.6, full temperature range); typicals for corner 2
.param VOS=if(CORNER==1, 4m, 0)
.param IB_REF=if(CORNER==1, 100n, if(CORNER==3, 0, 7n))
.param IB_C5=if(CORNER==3, 50n, if(CORNER==1, 0, 3.5n))
.param VOLC=if(CORNER==1, 0.55, 0.05)
.param IQ=if(CORNER==1, 800u, 450u)
.param VS_MIN=2
.param RON_CMP=100

* ---- reference divider and gate network
.param R4N=1.8e6
.param R5N=1.0e6
.param R23N=4.7e6
.param KT=if(CORNER==1, 1-RTOL, if(CORNER==3, 1+RTOL, 1))
.param KB=if(CORNER==1, 1+RTOL, if(CORNER==3, 1-RTOL, 1))

* ---- diodes: drop at microamps; corner 1 = model fitted to the BAS116 VF maxima
.param IS_D=if(CORNER==1, 1e-12, if(CORNER==3, 4.6e-10, 1.5e-10))
.model DSIG D(Is={IS_D} N=1.68 Rs=0.88 Cjo=2p BV=75 Ibv=100n)

* ---- loads (constant power) on VOUT; VOUT capacitance incl. the Pi regulator (assumption, SPEC 4)
.param P_FULL=42
.param P_USB=17
.param VUV=4.5
.param CVOUT=674u
.param T_PISD=3

* ---- timing (s)
.param T_PLUG=10m
.param TEDGE=1m
.param T_ON1=1
.param T_OFF1=5
.param T_ON2=190
.param T_OFF2=194
.param T_ON3=200
.param T_OFF3=202
.param T_BLIP=390
.param T_BLIPW=40m
.param T_STOP=580
.param T_OFFCHK=5
* FORCE=1: ACC stays off; SW1 on from T_ON1 to T_SW_OFF (separate run): SW1 acts like the key
.param FORCE=0
.param T_SW_OFF=40
.param VACC_HI={VB*(1-FORCE)}

* ---- battery, harness R + L (assumption), hot-plug step at T_PLUG
.param RHARN=50m
.param LHARN=1u
VBAT bsrc 0 PWL(0 0 {T_PLUG} 0 {T_PLUG+1u} {VB})
RH bsrc bh {RHARN}
LH bh batt {LHARN}
.model TVS D(Is=1e-12 N=1.5 Rs=50m BV=18.8 Ibv=1m)
DTVS1 0 batt TVS
C8 batt 0 100n

* ---- ACC: key switch and wire, TVS2, D5 into ACC_S; SW1 + D4 from BATT to ACC_S; R8 pull-down
VACC acc_src 0 PWL(0 0 {T_ON1} 0 {T_ON1+TEDGE} {VACC_HI} {T_OFF1} {VACC_HI} {T_OFF1+TEDGE} 0
+ {T_ON2} 0 {T_ON2+TEDGE} {VACC_HI} {T_OFF2} {VACC_HI} {T_OFF2+TEDGE} 0
+ {T_ON3} 0 {T_ON3+TEDGE} {VACC_HI} {T_OFF3} {VACC_HI} {T_OFF3+TEDGE} 0
+ {T_BLIP} 0 {T_BLIP+TEDGE} {VACC_HI} {T_BLIP+T_BLIPW} {VACC_HI} {T_BLIP+T_BLIPW+TEDGE} 0)
RACC acc_src acc 0.1
DTVS2 0 acc TVS
D5 acc accs DSIG
VSW swc 0 PWL(0 0 {T_ON1} 0 {T_ON1+TEDGE} {FORCE} {T_SW_OFF} {FORCE} {T_SW_OFF+TEDGE} 0)
SSW1 batt swd swc 0 SWK
D4 swd accs DSIG
.model SWK SW(Vt=0.5 Vh=0 Ron=50m Roff=1e12)
R8 accs 0 47k

* ---- timer: R24 + D6 charge C5 from ACC_S; R9 discharges it
R24 accs chg 1k
D6 chg c5 DSIG
C5 c5 0 Q=C5NOM*CF*(x-DCB*x*x/2)
R9 c5 0 {R9NOM*RF}
RIRC c5 0 {RIR}
BLK c5 chg I={ILEAK}*0.5*(1+tanh((V(c5)-V(chg))/50m))

* ---- reference with hysteresis
R4 batt ref {R4N*KT}
R5 ref 0 {R5N*KB}
R23 ref drv {R23N*KB}

* ---- U1 LM2903B stand-in (both halves). son = supply above the minimum
BSON son 0 V=0.5*(1+tanh((V(batt)-VS_MIN)/0.1))
BIQ batt 0 I={IQ}*V(son)
BIB1 0 c5 I={IB_C5}*V(son)
BIB2 0 ref I={IB_REF}*V(son)
* U1A: sinks while IN- (C5_T) > IN+ (REF) + offset
BCA ca 0 V=if(V(batt)>VS_MIN, V(c5)-V(ref)-VOS, -1)
RCA ca caf 1k
CCA caf 0 1n
SU1A drv ola caf 0 SWCMP
VOLA ola 0 {VOLC}
* U1B: sinks while IN- (ACC_S) > IN+ (REF) + offset
BCB cb 0 V=if(V(batt)>VS_MIN, V(accs)-V(ref)-VOS, -1)
RCB cb cbf 1k
CCB cbf 0 1n
SU1B stat olb cbf 0 SWCMP
VOLB olb 0 {VOLC}
.model SWCMP SW(Vt=0 Vh=0.5m Ron={RON_CMP} Roff=1e12)

* ---- status to the Pi: R21 to J5, Pi GPIO pull-up (assumption)
.param VPI=3.3
R21 stat j5 1.5k
RPI j5 pi3v3 50k
VPI3 pi3v3 0 {VPI}

* ---- Q1 and its gate network (no slew capacitor); threshold at the corner
.param VTO_P=if(CORNER==1, -2.5, if(CORNER==3, -1.1, -2.0))
R14 batt gate 220k
R15 gate drv 180k
M1 q1d gate batt batt PFET
.model PFET VDMOS(pchan Vto={VTO_P} Kp=40 Rd=4m Rs=2m Rb=5m Cgdmax=2.2n Cgdmin=0.35n Cgs=2.5n Cjo=1n Is=1e-12)
VSNS q1d vout 0

* ---- VOUT: capacitance (with ESR), LED D3 + R3, constant-power load with an undervoltage cut-off
CVO vout cvo {CVOUT}
RCVO cvo 0 20m
D3 vout d3k LEDR
R3 d3k 0 5.1k
.model LEDR D(Is=1e-22 N=1.6 Rs=5)
.param P2=if(LOAD==1, P_USB, P_FULL)
VPW pw 0 PWL(0 {P_FULL} {T_OFF1+T_PISD} {P_FULL} {T_OFF1+T_PISD+TEDGE} {P2} {T_ON2} {P2} {T_ON2+TEDGE} {P_FULL}
+ {T_OFF3+T_PISD} {P_FULL} {T_OFF3+T_PISD+TEDGE} {P2} {T_BLIP} {P2} {T_BLIP+TEDGE} {P_FULL})
BLOAD vout 0 I=V(pw)/max(V(vout),VUV)*0.5*(1+tanh((V(vout)-VUV)/0.2))

.options method=gear
.tran 0 {T_STOP} 0 10m uic

* ---- delays: ACC (or SW1) falling edge to VOUT falling through VB/2
.meas TRAN delay_keyoff TRIG V(acc) VAL={VB/2} TD={T_OFF1-0.5} FALL=1 TARG V(vout) VAL={VB/2} TD={T_OFF1} FALL=1
.meas TRAN delay_restart TRIG V(acc) VAL={VB/2} TD={T_OFF3-0.5} FALL=1 TARG V(vout) VAL={VB/2} TD={T_OFF3} FALL=1
.meas TRAN delay_blip TRIG V(acc) VAL={VB/2} TD={T_BLIP} FALL=1 TARG V(vout) VAL={VB/2} TD={T_BLIP} FALL=1
.meas TRAN delay_sw_off TRIG V(swc) VAL=0.5 TD={T_SW_OFF-0.5} FALL=1 TARG V(vout) VAL={VB/2} TD={T_SW_OFF} FALL=1
* VOUT stays on from the second key-on to the final key-off (restart mid-delay)
.param T_SETTLE=0.5
.meas TRAN vmin_restart MIN V(vout) FROM {T_ON2+T_SETTLE} TO {T_OFF3}
* chatter / re-latch after T_ON1: exactly three VOUT turn-ons and three DRV releases are expected
.meas TRAN vout_rise4 FIND time WHEN V(vout)={VB/2} TD={T_ON1-0.5} RISE=4
.meas TRAN drv_rise4 FIND time WHEN V(drv)={VB/2} TD={T_ON1-0.5} RISE=4
.meas TRAN vout_fall4 FIND time WHEN V(vout)={VB/2} TD={T_ON1-0.5} FALL=4
* residual VOUT before each next ACC edge (also catches a timer that never times out)
.meas TRAN vmax_off1 MAX V(vout) FROM {T_ON2-T_OFFCHK} TO {T_ON2-TEDGE}
.meas TRAN vmax_off2 MAX V(vout) FROM {T_BLIP-T_OFFCHK} TO {T_BLIP-TEDGE}
.meas TRAN vmax_off3 MAX V(vout) FROM {T_STOP-T_OFFCHK} TO {T_STOP}
* battery hot-plug: VOUT pulse, and VOUT back near 0 before the key-on
.meas TRAN hotplug_vmax MAX V(vout) FROM 0 TO {T_ON1}
.meas TRAN hotplug_vend FIND V(vout) AT {T_ON1-TEDGE}
.meas TRAN hotplug_q1e INTEG (V(batt)-V(q1d))*I(VSNS) FROM 0 TO {T_ON1}
.meas TRAN hotplug_vgs MAX V(batt)-V(gate) FROM 0 TO {T_ON1}
* key-on inrush: peak Q1 current and power, energy, VOUT 10-90 % rise time
.meas TRAN inrush_pk MAX I(VSNS) FROM {T_ON1} TO {T_ON1+T_SETTLE}
.meas TRAN q1_on_pk MAX (V(batt)-V(q1d))*I(VSNS) FROM {T_ON1} TO {T_ON1+T_SETTLE}
.meas TRAN q1_on_e INTEG (V(batt)-V(q1d))*I(VSNS) FROM {T_ON1} TO {T_ON1+50m}
.meas TRAN vout_tr TRIG V(vout) VAL={0.1*VB} TD={T_ON1} RISE=1 TARG V(vout) VAL={0.9*VB} TD={T_ON1} RISE=1
.meas TRAN batt_min_on MIN V(batt) FROM {T_ON1} TO {T_ON1+T_SETTLE}
* turn-off: peak Q1 power at the time-out (window covers the time-out of the first delay)
.meas TRAN q1_off_pk MAX (V(batt)-V(q1d))*I(VSNS) FROM {T_OFF1+8} TO {T_ON2-TEDGE}
* gate drive while on, VGS while parked
.meas TRAN vgs_on_min MIN V(batt)-V(gate) FROM {T_ON1+T_SETTLE} TO {T_OFF1}
.meas TRAN vgs_off_max MAX V(batt)-V(gate) FROM {T_ON2-T_OFFCHK} TO {T_ON2-TEDGE}
.meas TRAN q1_drop FIND V(batt)-V(vout) AT {T_OFF1-T_SETTLE}
* timer start, trip level, BATT before and after the Pi shuts down
.meas TRAN c5_v0 FIND V(c5) AT {T_OFF1}
.meas TRAN ref_on FIND V(ref) AT {T_OFF1+1}
.meas TRAN ref_off FIND V(ref) AT {T_ON2-1}
.meas TRAN batt_delay1 FIND V(batt) AT {T_OFF1+1}
.meas TRAN batt_delay2 FIND V(batt) AT {T_OFF1+T_PISD+1}
.meas TRAN batt_parked FIND V(batt) AT {T_ON2-1}
* J5 (ACC status): level while on, released level, release time after key-off and after SW1 opens
.meas TRAN j5_max_on MAX V(j5) FROM {T_ON1+T_SETTLE} TO {T_OFF1}
.meas TRAN j5_min_off MIN V(j5) FROM {T_OFF1+T_SETTLE} TO {T_ON2}
.meas TRAN j5_rel TRIG V(acc) VAL={VB/2} TD={T_OFF1-0.5} FALL=1 TARG V(j5) VAL={VPI/2} TD={T_OFF1} RISE=1
.meas TRAN j5_rel_sw TRIG V(swc) VAL=0.5 TD={T_SW_OFF-0.5} FALL=1 TARG V(j5) VAL={VPI/2} TD={T_SW_OFF} RISE=1
.meas TRAN j5_max_sw MAX V(j5) FROM {T_ON1+T_SETTLE} TO {T_SW_OFF}
.meas TRAN vmin_sw MIN V(vout) FROM {T_ON1+T_SETTLE} TO {T_SW_OFF}
.meas TRAN i_sw1_pk MAX I(SSW1) FROM {T_ON1} TO {T_ON1+T_SETTLE}
.meas TRAN led_on FIND I(D3) AT {T_OFF1-T_SETTLE}
.backanno
.end
